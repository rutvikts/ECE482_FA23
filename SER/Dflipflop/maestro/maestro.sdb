ADE simulation setup
Run mode: Single Run, Sweeps and Corners
Tests:
  SER_Dflipflop_1: SER/Dflipflop/schematic, simulator spectre
