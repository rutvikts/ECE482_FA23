ADE simulation setup
Test SER_Dflipflop_1: SER/Dflipflop/schematic, simulator spectre
  Models: /class/ece482/gpdk045_v_5_0/gpdk045/../models/spectre/gpdk045.scs[mc]
  Temperature: 27
  Analysis tran: stop=20n
Run mode: Single Run, Sweeps and Corners
